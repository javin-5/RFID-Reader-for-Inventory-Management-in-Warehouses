# Ansys Electronics Desktop project, version 2023.2
materials:
  vacuum: permittivity=1

design HFSSDesign1 (HFSS, HFSS Terminal Network, model units mm)
geometry:
  PIFA1 = component(PIFA, 3D_Component_File_Path=<syslib>/3DComponents/HFSS/Antennas/PIFA/PIFA_1.7GHz_DT.a3dcomp, Length2=1.14cm, subH=62mil, Antenna_Trace_Width=0.21cm, Feed_Length=0.021cm, subX=7.1cm, Feed_Width=0.21cm, Length1=3.54cm, Antenna_Offset=0.64cm, Feed_Offset=-0.71cm, subY=14.2cm)
  sub [my_mat_ADK] = part_of(PIFA1)
  Ground, antenna, microstrip_feed, port1 [pec] = part_of(PIFA1)
boundaries and excitations:
  PIFA1_Ground: Perfect E Objects=Ground
  PIFA1_antenna: Perfect E Objects=antenna
  PIFA1_microstrip_feed: Perfect E Objects=microstrip_feed
  PIFA1_microstrip_feed_T1: Terminal port=PIFA1_p1 Edges=microstrip_feed.edge(at (-7.1, -0.21, 0)) TerminalResistance=50ohm
  PIFA1_p1: Lumped Port Faces=port1.face(at (-7.1, -0.21, -0.7874)) LumpedPortType=Terminal Impedance=50ohm
setups:
  Setup1: HfssDrivenAuto AutoSolverSetting=Balanced SaveAnyFields=false Type=Interpolating
    sweep Sweep: 0GHz to 10GHz, 501 points;
source amplitudes:
  PIFA1_p1:1: 1V 0deg
